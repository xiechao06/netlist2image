* Series RL phasor (single frequency)
Vin in 0 DC 0 AC 1
R1 in nrl 10
L1 nrl 0 47m
.ac lin 1 50 50
.print ac V(nrl)
.end
