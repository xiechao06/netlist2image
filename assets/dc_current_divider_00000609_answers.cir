* DC current divider
Is 0 v DC 2.088
R1 v 0 20
R2 v 0 15
.op
.print dc V(v)
.end
