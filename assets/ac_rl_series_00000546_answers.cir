* Series RL phasor (single frequency)
Vin in 0 DC 0 AC 1
R1 in nrl 100
L1 nrl 0 47m
.ac lin 1 500 500
.print ac V(nrl)
.end
