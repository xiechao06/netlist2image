* Op-amp inverting amplifier with input-node feedback (Schaum's Fig. 6-37)
Vs in 0 DC 3.25
R1 in n1 6.8k
R2 n1 0 10k
R3 n1 inv 1.2k
Rf1 n1 out 1.5k
Rf2 out inv 150k
.subckt IDEAL_OPAMP in+ in- out
Rin in+ in- 1000Meg
E1 out 0 in+ in- 1e6
.ends IDEAL_OPAMP

X1 0 inv out IDEAL_OPAMP
.op
.print dc V(out)
.end
