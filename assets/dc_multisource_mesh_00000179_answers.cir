* DC multi-source series mesh — Schaum's Fig. 3-27
V1 n1 0 DC 24
R1 n1 a 5
R2 a nc 3
V2 nc nd DC 23
R3 nd ne 4
V3 b ne DC 18.2
V4 nf b DC 8.4
R4 nf 0 1
.op
.print dc V(a) V(b)
.end
