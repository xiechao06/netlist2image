* DC nodal: Vs+Rs series, Rp shunt, Is current source
Vs vsrc 0 DC 114
Rs vsrc v 2
Rp v 0 25
Is 0 v DC 0.04
.op
.print dc V(v)
.end
