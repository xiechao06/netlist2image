* Op-amp inverting amplifier
VCC vcc 0 DC 10.63
VEE vee 0 DC -10.63
Vin in 0 DC 0.3398 AC 1
Rin in nin 82k
Rf nin out 1.2Meg
Rgnd nplus 0 10k
Cpole nin out 10p
.subckt IDEAL_OPAMP in+ in- out vcc vee
Rin in+ in- 1Meg
Rout mid out 75
E1 mid 0 in+ in- 1e5
.ends IDEAL_OPAMP

X1 nplus nin out vcc vee IDEAL_OPAMP
.ac dec 50 1 100Meg
.print ac V(out)
.end
