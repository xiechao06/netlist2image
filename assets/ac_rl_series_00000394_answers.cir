* Series RL phasor (single frequency)
Vin in 0 DC 0 AC 1
R1 in nrl 18
L1 nrl 0 47m
.ac lin 1 100 100
.print ac V(nrl)
.end
