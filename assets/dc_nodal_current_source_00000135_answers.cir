* DC nodal: Vs+Rs series, Rp shunt, Is current source
Vs vsrc 0 DC 87
Rs vsrc v 10
Rp v 0 50
Is 0 v DC 0.1
.op
.print dc V(v)
.end
