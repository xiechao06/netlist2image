* Non-inverting op-amp
Vs in 0 DC 1.08
Ra in nplus 2.2k
Rdiv nplus 0 1.5k
Rf out minus 8.2k
Rs minus 0 1.8k
.subckt IDEAL_OPAMP in+ in- out
Rin in+ in- 1000Meg
E1 out 0 in+ in- 1e6
.ends IDEAL_OPAMP

X1 nplus minus out IDEAL_OPAMP
.op
.print dc V(out) V(nplus)
.end
