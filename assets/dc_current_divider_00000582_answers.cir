* DC current divider
Is 0 v DC 11.514
R1 v 0 4
R2 v 0 25
.op
.print dc V(v)
.end
