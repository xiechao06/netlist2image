* Half-wave rectifier with filter capacitor
Vin in 0 SIN(0 17.92 60 0 0)
D1 in out D1N4148
C1 out 0 3.3u
Rload out 0 390k
.model D1N4148 D (Is=2.52n Rs=0.568 N=1.752 Cjo=4p M=0.4 tt=20n)
.tran 1.667e-05 0.3333
.print tran V(out) V(in)
.end
