* Voltage divider — DC operating point
Vin in 0 DC 26.52
R1 in out 1.5Meg
R2 out 0 3.3Meg
.op
.print dc V(out)
.end
