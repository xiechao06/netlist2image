* Resistor network — Thevenin equivalent
Vs in 0 DC 29.02
Ra in n1 470
Rb n1 out 150
Rc out n2 33k
Rd n2 0 270
Rload out 0 2.7k
.op
.print dc V(out) I(Vs)
.end
