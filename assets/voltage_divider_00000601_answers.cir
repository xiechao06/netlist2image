* Voltage divider — DC operating point
Vin in 0 DC 4.162
R1 in out 1.8Meg
R2 out 0 470
.op
.print dc V(out)
.end
