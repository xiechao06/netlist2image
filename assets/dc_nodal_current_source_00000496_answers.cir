* DC nodal: Vs+Rs series, Rp shunt, Is current source
Vs vsrc 0 DC 93
Rs vsrc v 5
Rp v 0 25
Is 0 v DC -0.94
.op
.print dc V(v)
.end
