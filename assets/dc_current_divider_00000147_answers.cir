* DC current divider
Is 0 v DC 1.489
R1 v 0 15
R2 v 0 20
.op
.print dc V(v)
.end
