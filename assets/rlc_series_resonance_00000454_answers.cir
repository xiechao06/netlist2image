* Series RLC resonance
Vin in 0 AC 1
R1 in mid 3.3
L1 mid n1 4.7m
C1 n1 0 4.7u
.ac dec 500 10 10Meg
.print ac V(mid) V(n1)
.end
