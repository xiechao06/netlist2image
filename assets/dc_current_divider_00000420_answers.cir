* DC current divider
Is 0 v DC 34.654
R1 v 0 1
R2 v 0 20
.op
.print dc V(v)
.end
