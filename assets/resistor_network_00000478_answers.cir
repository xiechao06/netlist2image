* Resistor network — Thevenin equivalent
Vs in 0 DC 29.1
Ra in n1 150
Rb n1 out 470
Rc out n2 220k
Rd n2 0 270
Rload out 0 560k
.op
.print dc V(out) I(Vs)
.end
