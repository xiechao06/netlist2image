* DC nodal: Vs+Rs series, Rp shunt, Is current source
Vs vsrc 0 DC 72
Rs vsrc v 4
Rp v 0 100
Is 0 v DC 0.13
.op
.print dc V(v)
.end
