* RC low-pass filter
Vin in 0 AC 1
R1 in out 4.7Meg
C1 out 0 1.5u
.ac dec 50 0.01 10Meg
.print ac V(out)
.end
