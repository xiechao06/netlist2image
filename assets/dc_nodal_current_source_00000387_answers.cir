* DC nodal: Vs+Rs series, Rp shunt, Is current source
Vs vsrc 0 DC 64
Rs vsrc v 1
Rp v 0 100
Is 0 v DC -0.16
.op
.print dc V(v)
.end
