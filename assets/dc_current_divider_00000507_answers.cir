* DC current divider
Is 0 v DC 4.405
R1 v 0 10
R2 v 0 15
.op
.print dc V(v)
.end
