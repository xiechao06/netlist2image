* DC multi-source series mesh — Schaum's Fig. 3-27
V1 n1 0 DC 24.7
R1 n1 a 1
R2 a nc 4
V2 nc nd DC 31.7
R3 nd ne 2
V3 b ne DC 19.2
V4 nf b DC 13.5
R4 nf 0 2
.op
.print dc V(a) V(b)
.end
