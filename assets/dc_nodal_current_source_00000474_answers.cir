* DC nodal: Vs+Rs series, Rp shunt, Is current source
Vs vsrc 0 DC 27
Rs vsrc v 1
Rp v 0 25
Is 0 v DC 0.41
.op
.print dc V(v)
.end
