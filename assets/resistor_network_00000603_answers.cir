* Resistor network — Thevenin equivalent
Vs in 0 DC 9.12
Ra in n1 56k
Rb n1 out 390
Rc out n2 560
Rd n2 0 820
Rload out 0 3.9k
.op
.print dc V(out) I(Vs)
.end
