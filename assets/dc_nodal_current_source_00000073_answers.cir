* DC nodal: Vs+Rs series, Rp shunt, Is current source
Vs vsrc 0 DC 48
Rs vsrc v 8
Rp v 0 25
Is 0 v DC 0.07
.op
.print dc V(v)
.end
