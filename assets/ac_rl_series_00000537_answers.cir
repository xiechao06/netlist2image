* Series RL phasor (single frequency)
Vin in 0 DC 0 AC 1
R1 in nrl 820
L1 nrl 0 100m
.ac lin 1 60 60
.print ac V(nrl)
.end
