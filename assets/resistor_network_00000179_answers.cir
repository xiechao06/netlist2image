* Resistor network — Thevenin equivalent
Vs in 0 DC 27.54
Ra in n1 180
Rb n1 out 120
Rc out n2 47k
Rd n2 0 390
Rload out 0 56k
.op
.print dc V(out) I(Vs)
.end
