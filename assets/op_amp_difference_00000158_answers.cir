* Difference amplifier
Va ina 0 DC 5.63
Vb inb 0 DC 7.97
Ra ina minus 1.2k
Rb inb nplus 1.2k
Rc nplus 0 5.6k
Rf out minus 5.6k
.subckt IDEAL_OPAMP in+ in- out
Rin in+ in- 1000Meg
E1 out 0 in+ in- 1e6
.ends IDEAL_OPAMP

X1 nplus minus out IDEAL_OPAMP
.op
.print dc V(out)
.end
