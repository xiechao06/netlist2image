* DC current divider
Is 0 v DC 3.789
R1 v 0 15
R2 v 0 12
.op
.print dc V(v)
.end
