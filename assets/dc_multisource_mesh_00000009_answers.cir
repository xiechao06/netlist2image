* DC multi-source series mesh — Schaum's Fig. 3-27
V1 n1 0 DC 19.6
R1 n1 a 1
R2 a nc 3
V2 nc nd DC 25.6
R3 nd ne 5
V3 b ne DC 11.4
V4 nf b DC 14.1
R4 nf 0 4
.op
.print dc V(a) V(b)
.end
