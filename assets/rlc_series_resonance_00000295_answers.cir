* Series RLC resonance
Vin in 0 AC 1
R1 in mid 27
L1 mid n1 100m
C1 n1 0 2.2u
.ac dec 500 10 10Meg
.print ac V(mid) V(n1)
.end
