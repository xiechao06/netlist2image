* DC current divider
Is 0 v DC 14.163
R1 v 0 2
R2 v 0 15
.op
.print dc V(v)
.end
