* DC nodal: Vs+Rs series, Rp shunt, Is current source
Vs vsrc 0 DC 113.9
Rs vsrc v 20
Rp v 0 100
Is 0 v DC -0.02
.op
.print dc V(v)
.end
