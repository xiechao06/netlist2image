* BJT CE amplifier — β=300
VCC vcc 0 DC 19.65
Vin in 0 AC 1
Cin in base 33u
R1 vcc base 270k
R2 base 0 56k
RC vcc collector 5.6k
Q1 collector base emitter Q2N2222
RE emitter 0 1.5k
Cbypass emitter 0 3.3u
Cout collector out 68u
Rload out 0 56k
.model Q2N2222 NPN (Is=14.34f Xti=3 Eg=1.11 Vaf=74.03 Bf=300 Ne=1.307 Ise=14.34f Ikf=.2847 Xtb=1.5 Br=6.092 Nc=2 Isc=0 Ikr=0 Rc=1 Cjc=7.306p Mjc=.3416 Vjc=.75 Fc=.5 Cje=22.01p Mje=.377 Vje=.75 Tr=46.91n Tf=411.1p Itf=.6 Vtf=1.7 Xtf=3 Rb=10)
.ac dec 50 10 10Meg
.print ac V(out)
.end
