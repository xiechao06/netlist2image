* Resistor network — Thevenin equivalent
Vs in 0 DC 13.1
Ra in n1 150k
Rb n1 out 680
Rc out n2 120
Rd n2 0 270
Rload out 0 4.7k
.op
.print dc V(out) I(Vs)
.end
