* AC phasor — series RC single-frequency
Vin in 0 AC 1
R1 in out 120k
C1 out 0 220n
.ac lin 1 17.52k 17.52k
.print ac V(out)
.end
