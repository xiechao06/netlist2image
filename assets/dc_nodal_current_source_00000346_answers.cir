* DC nodal: Vs+Rs series, Rp shunt, Is current source
Vs vsrc 0 DC 76
Rs vsrc v 8
Rp v 0 40
Is 0 v DC -0.48
.op
.print dc V(v)
.end
