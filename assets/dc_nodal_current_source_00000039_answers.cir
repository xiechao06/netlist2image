* DC nodal: Vs+Rs series, Rp shunt, Is current source
Vs vsrc 0 DC 41
Rs vsrc v 5
Rp v 0 5
Is 0 v DC -1
.op
.print dc V(v)
.end
