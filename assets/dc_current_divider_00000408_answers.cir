* DC current divider
Is 0 v DC 2.307
R1 v 0 25
R2 v 0 10
.op
.print dc V(v)
.end
