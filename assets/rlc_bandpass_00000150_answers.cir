* RLC series band-pass filter  (output across R)
Vin in 0 AC 1
L1 in mid 100m
C1 mid out 220n
R1 out 0 180
.ac dec 500 10 10Meg
.print ac V(out)
.end
