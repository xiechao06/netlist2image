* Voltage divider — DC operating point
Vin in 0 DC 24.04
R1 in out 6.8Meg
R2 out 0 820
.op
.print dc V(out)
.end
