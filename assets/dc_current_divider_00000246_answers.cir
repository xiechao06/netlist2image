* DC current divider
Is 0 v DC 22.111
R1 v 0 1
R2 v 0 12
.op
.print dc V(v)
.end
