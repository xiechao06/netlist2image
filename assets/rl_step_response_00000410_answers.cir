* RL step response — transient analysis
Vin in 0 PWL(0 0 3.2353e-10 0 3.2385e-10 1.1587517498867104)
R1 in mid 6.8k
L1 mid 0 2.2m
.tran 3.235e-10 3.235e-06
.print tran I(L1)
.end
