* Resistor network — Thevenin equivalent
Vs in 0 DC 21.64
Ra in n1 220
Rb n1 out 22k
Rc out n2 680
Rd n2 0 820
Rload out 0 33k
.op
.print dc V(out) I(Vs)
.end
