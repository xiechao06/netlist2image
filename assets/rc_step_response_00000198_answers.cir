* RC step response — transient analysis
Vin in 0 PWL(0 0 6.8000e-03 0 6.8068e-03 1.9078733476696348)
R1 in out 100k
C1 out 0 68u
.tran 0.0068 68
.print tran V(out)
.end
