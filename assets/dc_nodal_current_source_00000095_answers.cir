* DC nodal: Vs+Rs series, Rp shunt, Is current source
Vs vsrc 0 DC 96
Rs vsrc v 8
Rp v 0 50
Is 0 v DC 0.05
.op
.print dc V(v)
.end
