* MOSFET CS amplifier
VDD vdd 0 DC 18.26
Vin in 0 AC 1
Cin in gate 3.3u
RG1 vdd gate 2.2Meg
RG2 gate 0 1.2Meg
RD vdd drain 10k
M1 drain gate source 0 NMOS1
RS source 0 5.6k
Cout drain out 4.7u
Rload out 0 100k
.model NMOS1 NMOS (Level=1 VTO=2.0 KP=1.0e-3 L=2e-6 W=50e-6 Lambda=0.0 Gamma=0.0 Phi=0.6)
.ac dec 50 10 10Meg
.print ac V(out)
.end
