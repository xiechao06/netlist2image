* Summing (inverting) op-amp, 3 inputs
Va ina 0 DC 3.11
Vb inb 0 DC 1.11
Vc inc 0 DC 1.69
Ra ina minus 2.2k
Rb inb minus 2.2k
Rc inc minus 2.2k
Rf out minus 2.2k
.subckt IDEAL_OPAMP in+ in- out
Rin in+ in- 1000Meg
E1 out 0 in+ in- 1e6
.ends IDEAL_OPAMP

X1 0 minus out IDEAL_OPAMP
.op
.print dc V(out)
.end
