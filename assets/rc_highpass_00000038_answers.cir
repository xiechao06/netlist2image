* RC high-pass filter
Vin in 0 AC 1
C1 in out 3.3n
R1 out 0 6.8Meg
.ac dec 50 0.01 10Meg
.print ac V(out)
.end
